* Voltage Source RC
V1 in 0 AC 1
R1 in out 10k
C1 out 0 10n
.ac dec 100 100 1Meg
.end
