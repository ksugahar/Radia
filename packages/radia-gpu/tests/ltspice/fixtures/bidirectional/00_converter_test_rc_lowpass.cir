* Extracted from ASC
I1 n1 0 AC 1
R1 n1 out 1k
C1 out 0 1u
.ac dec 100 1 100k
.end
