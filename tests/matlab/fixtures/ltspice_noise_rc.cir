* Radia noise analysis fixture
V1 in 0 AC 1
R1 in out 1k
C1 out 0 1u
.noise V(out) V1 dec 10 10 100k
.save V(out)
.end
