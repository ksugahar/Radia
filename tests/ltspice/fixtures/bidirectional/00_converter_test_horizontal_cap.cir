* Extracted from ASC
I1 n2 0 AC 1
C1 n2 n1 1u
C2 n1 out 100n
RL out 0 50
.ac dec 100 1k 1Meg
.end
