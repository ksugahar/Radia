* Extracted from ASC
I1 out 0 AC 1
L1 out 0 1m
C1 out 0 100n
.ac dec 100 1k 100k
.end
