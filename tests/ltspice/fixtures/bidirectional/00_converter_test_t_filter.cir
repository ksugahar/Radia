* Extracted from ASC
I1 n2 0 AC 1
L1 n2 n1 1m
C1 n1 0 100n
L2 n1 out 1m
RL out 0 50
.ac dec 100 1k 1Meg
.end
