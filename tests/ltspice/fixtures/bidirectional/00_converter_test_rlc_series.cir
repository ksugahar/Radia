* Extracted from ASC
I1 n2 0 AC 1
R1 n2 n1 100
L1 n1 out 10m
C1 out 0 1u
.ac dec 100 10 100k
.end
