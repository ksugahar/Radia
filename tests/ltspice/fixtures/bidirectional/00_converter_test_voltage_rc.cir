* Extracted from ASC
V1 n1 0 AC 1
R1 n1 out 10k
C1 out 0 10n
.ac dec 100 100 1Meg
.end
