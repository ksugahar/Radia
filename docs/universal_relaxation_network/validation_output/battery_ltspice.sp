* SPICE netlist generated by Universal Relaxation Network
* Port: BATTERY

R_inf BATTERY_p 1 0.0129538
* Debye 0: tau = 7.09e-03 s
R_debye0 2 3 0.000918278
C_debye0 2 3 7.72475
* Debye 1: tau = 2.54e-02 s
R_debye1 3 4 0.0012891
C_debye1 3 4 19.7412
* Debye 2: tau = 4.99e-02 s
R_debye2 4 5 0.001324
C_debye2 4 5 37.6715
* CPE 0: n = 0.315 (approximated)
R_cpe0_0 5 6 0.0203782
C_cpe0_0 6 0 1e-08
R_cpe0_1 6 7 0.203782
C_cpe0_1 7 0 1e-09
R_cpe0_2 7 8 2.03782
C_cpe0_2 8 0 1e-10
* CPE 1: n = 0.390 (approximated)
R_cpe1_0 8 9 0.0203782
C_cpe1_0 9 0 1e-08
R_cpe1_1 9 10 0.203782
C_cpe1_1 10 0 1e-09
R_cpe1_2 10 11 2.03782
C_cpe1_2 11 0 1e-10
* Skin effect 0: R_dc = 0.643502, delta = 1.35e-02
R_skin0_0 11 12 0.214501
L_skin0_0 12 0 1.96088e-05
R_skin0_1 12 13 0.1287
L_skin0_1 13 0 1.17653e-05
R_skin0_2 13 14 0.0919289
L_skin0_2 14 0 8.40377e-06
R_skin0_3 14 15 0.0715002
L_skin0_3 15 0 6.53627e-06
R_skin0_4 15 16 0.0585002
L_skin0_4 16 0 5.34786e-06
R_out 16 BATTERY_n 0

.end
* ============================================
* LTspice Simulation Directives
* ============================================

* Step response analysis
.tran 0 100m 0 1u

* AC analysis (Bode plot)
.ac dec 100 0.01 100k

* Input source (choose one):
* For step response:
V1 in 0 PULSE(0 1 0 1n 1n 100m 200m)

* For AC analysis:
* V1 in 0 AC 1

* Output node: "out"
.end
