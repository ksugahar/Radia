* SPICE netlist generated by Universal Relaxation Network
* Port: FERRITE

R_inf FERRITE_p 1 -115.893
* Debye 0: tau = 7.09e-08 s
R_debye0 2 3 160.215
C_debye0 2 3 4.42365e-10
* Debye 1: tau = 2.59e-06 s
R_debye1 3 4 190.075
C_debye1 3 4 1.36359e-08
* Debye 2: tau = 5.34e-06 s
R_debye2 4 5 191.216
C_debye2 4 5 2.79179e-08
* Debye 3: tau = 1.62e-08 s
R_debye3 5 6 140.755
C_debye3 5 6 1.15047e-10
* CPE 0: n = 0.414 (approximated)
R_cpe0_0 6 7 29.1999
C_cpe0_0 7 0 1e-08
R_cpe0_1 7 8 291.999
C_cpe0_1 8 0 1e-09
R_cpe0_2 8 9 2919.99
C_cpe0_2 9 0 1e-10
* Skin effect 0: R_dc = 1.65068, delta = 1.82e-02
R_skin0_0 9 10 0.550225
L_skin0_0 10 0 9.12946e-05
R_skin0_1 10 11 0.330135
L_skin0_1 11 0 5.47767e-05
R_skin0_2 11 12 0.235811
L_skin0_2 12 0 3.91262e-05
R_skin0_3 12 13 0.183408
L_skin0_3 13 0 3.04315e-05
R_skin0_4 13 14 0.150061
L_skin0_4 14 0 2.48985e-05
* Skin effect 1: R_dc = 8.49825, delta = 4.63e-01
R_skin1_0 14 15 2.83275
L_skin1_0 15 0 0.303038
R_skin1_1 15 16 1.69965
L_skin1_1 16 0 0.181823
R_skin1_2 16 17 1.21404
L_skin1_2 17 0 0.129873
R_skin1_3 17 18 0.944249
L_skin1_3 18 0 0.101013
R_skin1_4 18 19 0.772568
L_skin1_4 19 0 0.0826467
R_out 19 FERRITE_n 0

.end
* ============================================
* LTspice Simulation Directives
* ============================================

* Step response analysis
.tran 0 100m 0 1u

* AC analysis (Bode plot)
.ac dec 100 0.01 100k

* Input source (choose one):
* For step response:
V1 in 0 PULSE(0 1 0 1n 1n 100m 200m)

* For AC analysis:
* V1 in 0 AC 1

* Output node: "out"
.end
