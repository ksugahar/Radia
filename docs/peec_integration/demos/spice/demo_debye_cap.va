`include "disciplines.vams"

// Debye Relaxation Capacitor Model
// epsilon(omega) = eps_inf + (eps_s - eps_inf) / (1 + j*omega*tau)
//
// Parameters:
//   C_0 = 4.427000e-14 F (geometry factor)
//   eps_s = 4.5 (static permittivity)
//   eps_inf = 4.2 (high-freq permittivity)
//   tau = 1.000000e-11 s (relaxation time)
//   sigma = 1.000000e-12 S/m (DC conductivity)
//
// Generated by Radia VerilogA Generator

module peec_debye_cap(p, n);
    inout p, n;
    electrical p, n;

    parameter real C_0 = 4.427000e-14;       // Geometry factor [F]
    parameter real eps_s = 4.5;       // Static permittivity
    parameter real eps_inf = 4.2;   // High-frequency permittivity
    parameter real tau = 1.000000e-11;       // Relaxation time [s]
    parameter real sigma_dc = 1.000000e-12; // DC conductivity [S/m]
    parameter real eps_0 = 8.854187817e-12;      // Vacuum permittivity [F/m]

    real omega, omega_tau, denom;
    real eps_re, eps_im;
    real C_eff, G_eff;

    analog begin
        omega = 2 * `M_PI * $freq;
        if (omega < 1e-10) omega = 1e-10;

        omega_tau = omega * tau;
        denom = 1 + omega_tau * omega_tau;

        // Debye formula: eps' and eps"
        eps_re = eps_inf + (eps_s - eps_inf) / denom;
        eps_im = (eps_s - eps_inf) * omega_tau / denom;

        // Add DC conductivity contribution to loss
        if (omega > 1e-10) begin
            eps_im = eps_im + sigma_dc / (omega * eps_0);
        end

        // Effective capacitance and loss conductance
        C_eff = eps_re * C_0;
        G_eff = omega * eps_im * C_0;

        // Constitutive relation: I = C*dV/dt + G*V
        I(p, n) <+ C_eff * ddt(V(p, n)) + G_eff * V(p, n);
    end
endmodule
