`include "disciplines.vams"

// Dowell Skin Effect Impedance Model
// Z(s) = R_dc * F(xi) + s * L_int_dc * G(xi)
// where xi = (d/2) / delta, delta = sqrt(2 / (omega * mu * sigma))
//
// Parameters:
//   R_dc = 1.724138e-03 Ohm
//   L_int_dc = 4.188790e-10 H
//   thickness = 1.000000e-04 m
//   sigma = 5.800000e+07 S/m
//   mu_r = 1.0
//
// Generated by Radia VerilogA Generator

module peec_dowell_skin(p, n);
    inout p, n;
    electrical p, n;

    // Physical parameters
    parameter real R_dc = 1.724138e-03;        // DC resistance [Ohm]
    parameter real L_int_dc = 4.188790e-10; // DC internal inductance [H]
    parameter real d = 1.000000e-04;      // Conductor thickness [m]
    parameter real sigma = 5.800000e+07;      // Conductivity [S/m]
    parameter real mu_r = 1.0;            // Relative permeability
    parameter real mu_0 = 1.2566370614e-6;          // Vacuum permeability [H/m]

    real omega, mu, delta, xi;
    real sh_2xi, ch_2xi, sn_2xi, cs_2xi;
    real F_R, F_L, denom;

    analog begin
        omega = 2 * `M_PI * $freq;
        if (omega < 1e-10) omega = 1e-10;  // Avoid DC singularity

        mu = mu_0 * mu_r;
        delta = sqrt(2.0 / (omega * mu * sigma));
        xi = (d / 2) / delta;  // Half-thickness / skin_depth

        // Compute Dowell factors F(xi) and G(xi)
        if (xi < 0.01) begin
            // Taylor series for small xi
            F_R = 1.0 + pow(xi, 4) / 45.0;
            F_L = 1.0 - pow(xi, 4) / 15.0;
        end else begin
            // Full Dowell formula
            sh_2xi = sinh(2*xi);
            ch_2xi = cosh(2*xi);
            sn_2xi = sin(2*xi);
            cs_2xi = cos(2*xi);

            denom = ch_2xi - cs_2xi;
            if (abs(denom) < 1e-30) denom = 1e-30;

            F_R = xi * (sh_2xi + sn_2xi) / denom;
            F_L = 1.5 / xi * (sh_2xi - sn_2xi) / denom;
        end

        // Constitutive relation: V = R_ac * I + L_ac * dI/dt
        V(p, n) <+ R_dc * F_R * I(p, n) + L_int_dc * F_L * ddt(I(p, n));
    end
endmodule
