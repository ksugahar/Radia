`include "disciplines.vams"

// Multi-Pole Debye Relaxation Capacitor Model
// epsilon(omega) = eps_inf + sum_k (Delta_eps_k / (1 + j*omega*tau_k))
//
// Number of poles: 2
// C_0 = 1.000000e-12 F
// eps_inf = 5.0
//
// Generated by Radia VerilogA Generator

module demo_multi_debye(p, n);
    inout p, n;
    electrical p, n;

    parameter real C_0 = 1.000000e-12;
    parameter real eps_inf = 5.0;

    // Debye poles (Delta_eps, tau pairs)
    parameter real Delta_eps_1 = 70.0;
    parameter real tau_1 = 8.300000e-12;
    parameter real Delta_eps_2 = 4.0;
    parameter real tau_2 = 1.000000e-13;

    real omega, eps_re, eps_im;
    real ot1, d1, ot2, d2;

    analog begin
        omega = 2 * `M_PI * $freq;
        if (omega < 1e-10) omega = 1e-10;

        // Compute denominators for each pole
        ot1 = omega * tau_1;
        d1 = 1 + ot1 * ot1;
        ot2 = omega * tau_2;
        d2 = 1 + ot2 * ot2;

        // Sum contributions
        eps_re = eps_inf + Delta_eps_1/d1 + Delta_eps_2/d2;
        eps_im = Delta_eps_1*ot1/d1 + Delta_eps_2*ot2/d2;

        I(p, n) <+ eps_re * C_0 * ddt(V(p, n)) + omega * eps_im * C_0 * V(p, n);
    end
endmodule
