* SPICE netlist generated by Universal Relaxation Network
* Port: FERRITE_URN

R_inf FERRITE_URN_p 1 -111.762
* Debye 0: tau = 2.90e-08 s
R_debye0 2 3 143.578
C_debye0 2 3 2.01836e-10
* Debye 1: tau = 1.58e-07 s
R_debye1 3 4 227.261
C_debye1 3 4 6.9358e-10
* Debye 2: tau = 1.77e-07 s
R_debye2 4 5 108.268
C_debye2 4 5 1.63249e-09
* Debye 3: tau = 1.13e-06 s
R_debye3 5 6 133.212
C_debye3 5 6 8.48563e-09
* Cole-Cole 0: tau = 1.92e-06 s, alpha = 0.374
* Charef RC ladder approximation (5 stages)
R_cc0_0 6 7 12.9891
C_cc0_0 7 0 2.63656e-08
R_cc0_1 7 8 12.9891
C_cc0_1 8 0 6.23758e-08
R_cc0_2 8 9 12.9891
C_cc0_2 9 0 1.47569e-07
R_cc0_3 9 10 12.9891
C_cc0_3 10 0 3.49119e-07
R_cc0_4 10 11 12.9891
C_cc0_4 11 0 8.25948e-07
* Cole-Cole 1: tau = 4.09e-05 s, alpha = 0.326
* Charef RC ladder approximation (5 stages)
R_cc1_0 11 12 10.7674
C_cc1_0 12 0 8.48427e-07
R_cc1_1 12 13 10.7674
C_cc1_1 13 0 1.79555e-06
R_cc1_2 13 14 10.7674
C_cc1_2 14 0 3.79999e-06
R_cc1_3 14 15 10.7674
C_cc1_3 15 0 8.04206e-06
R_cc1_4 15 16 10.7674
C_cc1_4 16 0 1.70197e-05
* Cole-Cole 2: tau = 5.20e-08 s, alpha = 0.502
* Charef RC ladder approximation (5 stages)
R_cc2_0 16 17 16.8501
C_cc2_0 17 0 3.05343e-10
R_cc2_1 17 18 16.8501
C_cc2_1 18 0 9.70541e-10
R_cc2_2 18 19 16.8501
C_cc2_2 19 0 3.08489e-09
R_cc2_3 19 20 16.8501
C_cc2_3 20 0 9.80544e-09
R_cc2_4 20 21 16.8501
C_cc2_4 21 0 3.11669e-08
* Warburg 0: Aw = 6.9253e-01
* Warburg RC ladder approximation (5 stages, n=0.5)
R_warburg0_0 21 22 0.0959773
C_warburg0_0 22 0 0.000524387
R_warburg0_1 22 23 0.0303507
C_warburg0_1 23 0 0.000165826
R_warburg0_2 23 24 0.00959773
C_warburg0_2 24 0 5.24387e-05
R_warburg0_3 24 25 0.00303507
C_warburg0_3 25 0 1.65826e-05
R_warburg0_4 25 26 0.001
C_warburg0_4 26 0 5.24387e-06
* CPE 0: Q = 2.8468e+00, n = 0.392, weight = 0.4460
* Valsa RC ladder approximation (5 stages)
R_cpe0_0 26 27 0.0128977
C_cpe0_0 27 0 0.001
R_cpe0_1 27 28 0.00318181
C_cpe0_1 28 0 0.001
R_cpe0_2 28 29 0.001
C_cpe0_2 29 0 0.000641184
R_cpe0_3 29 30 0.001
C_cpe0_3 30 0 0.000259908
R_cpe0_4 30 31 0.001
C_cpe0_4 31 0 0.000105355
* Skin effect 0: R_dc = 0.362382, delta = 2.52e-02
R_skin0_0 31 32 0.120794
L_skin0_0 32 0 3.84592e-05
R_skin0_1 32 33 0.0724765
L_skin0_1 33 0 2.30755e-05
R_skin0_2 33 34 0.0517689
L_skin0_2 34 0 1.64825e-05
R_skin0_3 34 35 0.0402647
L_skin0_3 35 0 1.28197e-05
R_skin0_4 35 36 0.0329439
L_skin0_4 36 0 1.04889e-05
* Skin effect 1: R_dc = 0.626237, delta = 1.14e-01
R_skin1_0 36 37 0.208746
L_skin1_0 37 0 0.00136692
R_skin1_1 37 38 0.125247
L_skin1_1 38 0 0.000820154
R_skin1_2 38 39 0.0894624
L_skin1_2 39 0 0.000585824
R_skin1_3 39 40 0.0695819
L_skin1_3 40 0 0.000455641
R_skin1_4 40 41 0.0569306
L_skin1_4 41 0 0.000372797
R_out 41 FERRITE_URN_n 0

.end
