* 1D Diffusion Skin Effect Model (PRIMA Ladder)
* Generated by Radia PEEC
* Conductor: d=0.100mm, sigma=5.80e+07S/m
* DC: R_dc=1.724e-04 Ohm*m^2, L_dc=4.189e-11 H*m^2

.SUBCKT SKIN_EFFECT in out
* 1D diffusion eigenmode expansion
* d = 1.000e-04 m, sigma = 5.800e+07 S/m
* R_dc = 1.724138e-04 Ohm*m^2
* L_dc = 4.188790e-11 H*m^2
* n_stages = 30
L1 in n1 1.256637e-10
R1 n1 0 1.000000e-15
L2 n1 n2 2.513274e-11
R2 n2 0 2.068966e-03
L3 n2 n3 1.396263e-11
R3 n3 0 4.827586e-03
L4 n3 n4 9.666439e-12
R4 n4 0 7.586207e-03
L5 n4 n5 7.391983e-12
R5 n5 0 1.034483e-02
L6 n5 n6 5.983986e-12
R6 n6 0 1.310345e-02
L7 n6 n7 5.026548e-12
R7 n7 0 1.586207e-02
L8 n7 n8 4.333231e-12
R8 n8 0 1.862069e-02
L9 n8 n9 3.807991e-12
R9 n9 0 2.137931e-02
L10 n9 n10 3.396316e-12
R10 n10 0 2.413793e-02
L11 n10 n11 3.064968e-12
R11 n11 0 2.689655e-02
L12 n11 n12 2.792527e-12
R12 n12 0 2.965517e-02
L13 n12 n13 2.564565e-12
R13 n13 0 3.241379e-02
L14 n13 n14 2.371013e-12
R14 n14 0 3.517241e-02
L15 n14 n15 2.204626e-12
R15 n15 0 3.793103e-02
L16 n15 n16 2.060061e-12
R16 n16 0 4.068966e-02
L17 n16 n17 1.933288e-12
R17 n17 0 4.344828e-02
L18 n17 n18 1.821213e-12
R18 n18 0 4.620690e-02
L19 n18 n19 1.721421e-12
R19 n19 0 4.896552e-02
L20 n19 n20 1.631996e-12
R20 n20 0 5.172414e-02
L21 n20 n21 1.551404e-12
R21 n21 0 5.448276e-02
L22 n21 n22 1.478397e-12
R22 n22 0 5.724138e-02
L23 n22 n23 1.411952e-12
R23 n23 0 6.000000e-02
L24 n23 n24 1.351223e-12
R24 n24 0 6.275862e-02
L25 n24 n25 1.295502e-12
R25 n25 0 6.551724e-02
L26 n25 n26 1.244195e-12
R26 n26 0 6.827586e-02
L27 n26 n27 1.196797e-12
R27 n27 0 7.103448e-02
L28 n27 n28 1.152878e-12
R28 n28 0 7.379310e-02
L29 n28 n29 1.112068e-12
R29 n29 0 7.655172e-02
L30 n29 out 1.074049e-12
R30 out 0 7.931034e-02
.ENDS

* Test circuit
V1 in 0 AC 1
X1 in out SKIN_EFFECT
R_load out 0 1e-6

.AC DEC 20 1 100MEG
.PRINT AC V(in) I(V1)
.END
