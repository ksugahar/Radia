* Dowell Surface Impedance Model
* Generated by Radia PEEC
* Conductor: d=0.100mm, sigma=5.80e+07S/m

.SUBCKT DOWELL_SKIN in out
* Dowell continued fraction expansion
* d = 1.000e-04 m, sigma = 5.800e+07 S/m
* R_dc = 1.724138e-04 Ohm*m^2
* tau = 3.644247e-07 s
* n_stages = 10
R1 in n1 1.724138e-04
R2 n1 n2 1.724138e-04
L1 n2 0 1.214749e-07
R3 n2 n3 1.724138e-04
L2 n3 0 7.288495e-08
R4 n3 n4 1.724138e-04
L3 n4 0 5.206068e-08
R5 n4 n5 1.724138e-04
L4 n5 0 4.049164e-08
R6 n5 n6 1.724138e-04
L5 n6 0 3.312952e-08
R7 n6 n7 1.724138e-04
L6 n7 0 2.803267e-08
R8 n7 n8 1.724138e-04
L7 n8 0 2.429498e-08
R9 n8 n9 1.724138e-04
L8 n9 0 2.143675e-08
R10 n9 n10 1.724138e-04
L9 n10 0 1.918025e-08
R11 n10 out 1.724138e-04
L10 out 0 1.735356e-08
.ENDS

* Test circuit
V1 in 0 AC 1
X1 in out DOWELL_SKIN
R_load out 0 1e-6

.AC DEC 20 1 100MEG
.PRINT AC V(in) I(V1)
.END
