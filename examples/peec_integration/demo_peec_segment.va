`include "disciplines.vams"

// Complete PEEC Segment Model
// Includes: R (with skin), L (internal + external), C (with Debye loss)
//
// R_dc = 9.852217e-03 Ohm
// L_self = 2.932153e-10 H
// L_ext = 5.377759e-09 H
// C_self = 9.518050e-13 F
// Skin effect: Yes (tau=2.232102e-08)
// Debye loss: Yes
//
// Generated by Radia VerilogA Generator

module demo_peec_segment(p, n);
    inout p, n;
    electrical p, n;

    parameter real R_dc = 9.852217e-03;
    parameter real L_int = 2.932153e-10;
    parameter real L_ext = 5.377759e-09;
    parameter real C_self = 9.518050e-13;
    parameter real tau_skin = 2.232102e-08;

    real omega, xi, F_R, F_L;
    real omega_tau, denom_d, eps_re, eps_im;
    real C_eff, G_dielectric;
    real L_total;

    analog begin
        omega = 2 * `M_PI * $freq;
        if (omega < 1e-10) omega = 1e-10;

        // Dowell skin effect
        xi = sqrt(tau_skin * omega / 2);
        if (xi < 0.1) begin
            F_R = 1.0 + pow(xi, 4) / 45.0;
            F_L = 1.0 - pow(xi, 4) / 15.0;
        end else begin
            F_R = xi * (sinh(2*xi) + sin(2*xi)) / (cosh(2*xi) - cos(2*xi));
            F_L = 1.5 / xi * (sinh(2*xi) - sin(2*xi)) / (cosh(2*xi) - cos(2*xi));
        end

        // Debye relaxation for capacitance
        omega_tau = omega * 1.000000e-10;
        denom_d = 1 + omega_tau * omega_tau;
        eps_re = 4.2139999999999995 + (4.386 - 4.2139999999999995) / denom_d;
        eps_im = (4.386 - 4.2139999999999995) * omega_tau / denom_d;
        C_eff = eps_re * C_self;
        G_dielectric = omega * eps_im * C_self;

        L_total = L_int * F_L + L_ext;

        // Series impedance: V = R_ac * I + L * dI/dt
        V(p, n) <+ R_dc * F_R * I(p, n);
        V(p, n) <+ L_total * ddt(I(p, n));

        // Shunt admittance: I = C * dV/dt + G * V
        I(p, n) <+ C_eff * ddt(V(p, n));
        I(p, n) <+ G_dielectric * V(p, n);
    end
endmodule
