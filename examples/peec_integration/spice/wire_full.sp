* PEEC-extracted SPICE netlist
* Wire: L=100mm, w=1.0mm, h=1.0mm
* Segments: 10

.SUBCKT WIRE_PEEC port_in port_out

* === Series RL Ladder ===
L1 port_in n1 5.601858e-09
L2 n1 n2 5.601858e-09
L3 n2 n3 5.601858e-09
L4 n3 n4 5.601858e-09
L5 n4 n5 5.601858e-09
L6 n5 n6 5.601858e-09
L7 n6 n7 5.601858e-09
L8 n7 n8 5.601858e-09
L9 n8 n9 5.601858e-09
L10 n9 port_out 5.601858e-09

* === Mutual Inductance ===
K1_2 L1 L2 1.785122e-01
K1_3 L1 L3 8.925610e-02
K1_4 L1 L4 5.950407e-02
K1_5 L1 L5 4.462805e-02
K1_6 L1 L6 3.570244e-02
K1_7 L1 L7 2.975203e-02
K1_8 L1 L8 2.550174e-02
K1_9 L1 L9 2.231403e-02
K1_10 L1 L10 1.983469e-02
K2_3 L2 L3 1.785122e-01
K2_4 L2 L4 8.925610e-02
K2_5 L2 L5 5.950407e-02
K2_6 L2 L6 4.462805e-02
K2_7 L2 L7 3.570244e-02
K2_8 L2 L8 2.975203e-02
K2_9 L2 L9 2.550174e-02
K2_10 L2 L10 2.231403e-02
K3_4 L3 L4 1.785122e-01
K3_5 L3 L5 8.925610e-02
K3_6 L3 L6 5.950407e-02
K3_7 L3 L7 4.462805e-02
K3_8 L3 L8 3.570244e-02
K3_9 L3 L9 2.975203e-02
K3_10 L3 L10 2.550174e-02
K4_5 L4 L5 1.785122e-01
K4_6 L4 L6 8.925610e-02
K4_7 L4 L7 5.950407e-02
K4_8 L4 L8 4.462805e-02
K4_9 L4 L9 3.570244e-02
K4_10 L4 L10 2.975203e-02
K5_6 L5 L6 1.785122e-01
K5_7 L5 L7 8.925610e-02
K5_8 L5 L8 5.950407e-02
K5_9 L5 L9 4.462805e-02
K5_10 L5 L10 3.570244e-02
K6_7 L6 L7 1.785122e-01
K6_8 L6 L8 8.925610e-02
K6_9 L6 L9 5.950407e-02
K6_10 L6 L10 4.462805e-02
K7_8 L7 L8 1.785122e-01
K7_9 L7 L9 8.925610e-02
K7_10 L7 L10 5.950407e-02
K8_9 L8 L9 1.785122e-01
K8_10 L8 L10 8.925610e-02
K9_10 L9 L10 1.785122e-01

.ENDS WIRE_PEEC

* === Test Circuit ===
Xwire port_in port_out WIRE_PEEC
Vin port_in 0 AC 1

* AC analysis: 1kHz to 100MHz
.AC DEC 10 1k 100MEG
.PRINT AC V(port_out) I(Vin)
.END
