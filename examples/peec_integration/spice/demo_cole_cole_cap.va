`include "disciplines.vams"

// Cole-Cole Relaxation Capacitor Model
// epsilon(omega) = eps_inf + (eps_s - eps_inf) / (1 + (j*omega*tau)^alpha)
//
// Parameters:
//   C_0 = 1.000000e-12 F (geometry factor)
//   eps_s = 100 (static permittivity)
//   eps_inf = 15 (high-freq permittivity)
//   tau = 1.000000e-09 s (relaxation time)
//   alpha = 0.7 (distribution parameter, 0 < alpha <= 1)
//   sigma = 1.000000e-02 S/m (DC conductivity)
//
// Generated by Radia VerilogA Generator

module peec_cole_cole_cap(p, n);
    inout p, n;
    electrical p, n;

    parameter real C_0 = 1.000000e-12;
    parameter real eps_s = 100;
    parameter real eps_inf = 15;
    parameter real tau = 1.000000e-09;
    parameter real alpha = 0.7;
    parameter real sigma_dc = 1.000000e-02;
    parameter real eps_0 = 8.854187817e-12;

    real omega, x, theta;
    real denom_re, denom_im, denom_mag2;
    real eps_re, eps_im;
    real C_eff, G_eff;

    analog begin
        omega = 2 * `M_PI * $freq;
        if (omega < 1e-10) omega = 1e-10;

        // (j*omega*tau)^alpha = (omega*tau)^alpha * exp(j*alpha*pi/2)
        x = pow(omega * tau, alpha);
        theta = alpha * `M_PI / 2;

        // 1 + (j*omega*tau)^alpha
        denom_re = 1 + x * cos(theta);
        denom_im = x * sin(theta);
        denom_mag2 = denom_re * denom_re + denom_im * denom_im;

        if (denom_mag2 < 1e-30) denom_mag2 = 1e-30;

        // eps = eps_inf + (eps_s - eps_inf) / denom
        eps_re = eps_inf + (eps_s - eps_inf) * denom_re / denom_mag2;
        eps_im = (eps_s - eps_inf) * denom_im / denom_mag2;

        // Add DC conductivity contribution
        if (omega > 1e-10) begin
            eps_im = eps_im + sigma_dc / (omega * eps_0);
        end

        C_eff = eps_re * C_0;
        G_eff = omega * eps_im * C_0;

        I(p, n) <+ C_eff * ddt(V(p, n)) + G_eff * V(p, n);
    end
endmodule
