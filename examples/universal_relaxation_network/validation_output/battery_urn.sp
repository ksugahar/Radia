* SPICE netlist generated by Universal Relaxation Network
* Port: BATTERY_URN

R_inf BATTERY_URN_p 1 -0.00532761
* Debye 0: tau = 7.08e-03 s
R_debye0 2 3 0.000445123
C_debye0 2 3 15.9084
* Debye 1: tau = 2.53e-02 s
R_debye1 3 4 0.000617573
C_debye1 3 4 40.8971
* Debye 2: tau = 4.95e-02 s
R_debye2 4 5 0.000638116
C_debye2 4 5 77.6064
* Cole-Cole 0: tau = 4.63e-02 s, alpha = 0.487
* Charef RC ladder approximation (5 stages)
R_cc0_0 5 6 0.001
C_cc0_0 6 0 0.001
R_cc0_1 6 7 0.001
C_cc0_1 7 0 0.001
R_cc0_2 7 8 0.001
C_cc0_2 8 0 0.001
R_cc0_3 8 9 0.001
C_cc0_3 9 0 0.001
R_cc0_4 9 10 0.001
C_cc0_4 10 0 0.001
* Cole-Cole 1: tau = 2.83e-04 s, alpha = 0.432
* Charef RC ladder approximation (5 stages)
R_cc1_0 10 11 0.001
C_cc1_0 11 0 0.001
R_cc1_1 11 12 0.001
C_cc1_1 12 0 0.001
R_cc1_2 12 13 0.001
C_cc1_2 13 0 0.001
R_cc1_3 13 14 0.001
C_cc1_3 14 0 0.001
R_cc1_4 14 15 0.001
C_cc1_4 15 0 0.001
* Warburg 0: Aw = 3.6623e-01
* Warburg RC ladder approximation (5 stages, n=0.5)
R_warburg0_0 15 16 0.001
C_warburg0_0 16 0 0.001
R_warburg0_1 16 17 0.001
C_warburg0_1 17 0 0.001
R_warburg0_2 17 18 0.001
C_warburg0_2 18 0 0.001
R_warburg0_3 18 19 0.001
C_warburg0_3 19 0 0.001
R_warburg0_4 19 20 0.001
C_warburg0_4 20 0 0.001
* Warburg 1: Aw = 9.6845e-02
* Warburg RC ladder approximation (5 stages, n=0.5)
R_warburg1_0 20 21 0.001
C_warburg1_0 21 0 0.001
R_warburg1_1 21 22 0.001
C_warburg1_1 22 0 0.001
R_warburg1_2 22 23 0.001
C_warburg1_2 23 0 0.001
R_warburg1_3 23 24 0.001
C_warburg1_3 24 0 0.001
R_warburg1_4 24 25 0.001
C_warburg1_4 25 0 0.001
* CPE 0: Q = 5.0724e+00, n = 0.316, weight = 0.0041
* Valsa RC ladder approximation (5 stages)
R_cpe0_0 25 26 0.001
C_cpe0_0 26 0 0.001
R_cpe0_1 26 27 0.001
C_cpe0_1 27 0 0.001
R_cpe0_2 27 28 0.001
C_cpe0_2 28 0 0.001
R_cpe0_3 28 29 0.001
C_cpe0_3 29 0 0.001
R_cpe0_4 29 30 0.001
C_cpe0_4 30 0 0.001
* CPE 1: Q = 4.4136e-01, n = 0.390, weight = 0.0042
* Valsa RC ladder approximation (5 stages)
R_cpe1_0 30 31 0.001
C_cpe1_0 31 0 0.001
R_cpe1_1 31 32 0.001
C_cpe1_1 32 0 0.001
R_cpe1_2 32 33 0.001
C_cpe1_2 33 0 0.001
R_cpe1_3 33 34 0.001
C_cpe1_3 34 0 0.001
R_cpe1_4 34 35 0.001
C_cpe1_4 35 0 0.001
* Skin effect 0: R_dc = 0.648232, delta = 1.36e-02
R_skin0_0 35 36 0.216077
L_skin0_0 36 0 1.99502e-05
R_skin0_1 36 37 0.129646
L_skin0_1 37 0 1.19701e-05
R_skin0_2 37 38 0.0926046
L_skin0_2 38 0 8.55009e-06
R_skin0_3 38 39 0.0720258
L_skin0_3 39 0 6.65007e-06
R_skin0_4 39 40 0.0589302
L_skin0_4 40 0 5.44096e-06
R_out 40 BATTERY_URN_n 0

.end
